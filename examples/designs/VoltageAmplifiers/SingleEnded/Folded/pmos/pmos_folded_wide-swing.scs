parameters vcm=1.65 vout_dc=2.532
subckt amp (VINN VINP VOUT vdd vss)
M1a (n01 VINP n02 vdd) sg13_hv_pmos l=900n w=28.74u
M1b (n03 VINN n02 vdd) sg13_hv_pmos l=900n w=28.74u
M2a (n01 vbn vss vss) sg13_hv_nmos l=500n w=42.83u
M2b (n03 vbn vss vss) sg13_hv_nmos l=500n w=42.83u
M3a (n04 vcascn n01 vss) sg13_hv_nmos l=400n w=7.265u
M3b (VOUT vcascn n03 vss) sg13_hv_nmos l=400n w=7.265u
M4a (n04 vcascp n05 vdd) sg13_hv_pmos l=400n w=10.3u
M4b (VOUT vcascp n06 vdd) sg13_hv_pmos l=400n w=10.3u
M5a (n05 n04 vdd vdd) sg13_hv_pmos l=400n w=10.3u
M5b (n06 n04 vdd vdd) sg13_hv_pmos l=400n w=10.3u
M6 (n02 vbtail vdd vdd) sg13_hv_pmos l=400n w=20.23u
VBTAIL (vbtail vss) vsource dc=2.532
VCASCN (vcascn vss) vsource dc=2.089
VBN (vbn vss) vsource dc=706.2m
VCASCP (vcascp vss) vsource dc=1.374
ends amp
