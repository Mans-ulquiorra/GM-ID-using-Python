parameters vcm=1.65 vout_dc=754.6m
subckt amp (VINN VINP VOUT vdd vss)
M1a (n01 VINP n02 vdd) sg13_hv_pmos l=400n w=42.58u
M1b (n03 VINN n02 vdd) sg13_hv_pmos l=400n w=42.58u
M2a (n04 vcascp n01 vdd) sg13_hv_pmos l=400n w=23.54u
M2b (VOUT vcascp n03 vdd) sg13_hv_pmos l=400n w=23.54u
M3a (n04 vcascn n05 vss) sg13_hv_nmos l=400n w=14.91u
M3b (VOUT vcascn n06 vss) sg13_hv_nmos l=400n w=14.91u
M4a (n05 n04 vss vss) sg13_hv_nmos l=400n w=14.47u
M4b (n06 n04 vss vss) sg13_hv_nmos l=400n w=14.47u
M5 (n02 vbp vdd vdd) sg13_hv_pmos l=400n w=31.96u
VCASCN (vcascn vss) vsource dc=1.294
VCASCP (vcascp vss) vsource dc=1.175
VBP (vbp vss) vsource dc=2.532
ends amp
