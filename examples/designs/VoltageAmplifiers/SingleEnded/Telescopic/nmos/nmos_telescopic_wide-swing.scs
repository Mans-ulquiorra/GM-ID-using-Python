parameters vcm=1.65 vout_dc=2.573
subckt amp (VINN VINP VOUT vdd vss)
M1a (n01 VINP n02 vss) sg13_hv_nmos l=448.9n w=23.73u
M1b (n03 VINN n02 vss) sg13_hv_nmos l=448.9n w=23.73u
M2a (n04 vcascn n01 vss) sg13_hv_nmos l=400.2n w=12.9u
M2b (VOUT vcascn n03 vss) sg13_hv_nmos l=400.2n w=12.9u
M3a (n04 vcascp n05 vdd) sg13_hv_pmos l=400.3n w=18.46u
M3b (VOUT vcascp net2 vdd) sg13_hv_pmos l=400.3n w=18.46u
M4a (n05 n04 vdd vdd) sg13_hv_pmos l=400n w=18.96u
M4b (net2 n04 vdd vdd) sg13_hv_pmos l=400n w=18.96u
M5 (n02 vbn vss vss) sg13_hv_nmos l=402.4n w=5.803u
VCASCN (vcascn vss) vsource dc=2.137
VBN (vbn vss) vsource dc=853.2m
VCASCP (vcascp vss) vsource dc=2.128
ends amp
