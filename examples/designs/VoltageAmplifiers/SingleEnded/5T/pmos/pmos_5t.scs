parameters vcm=600m vout_dc=450.9m
subckt amp (VINN VINP VOUT vdd vss)
M1a (n01 VINP n02 vdd) pch_lvt l=240.1n w=5.874u
M1b (VOUT VINN n02 vdd) pch_lvt l=240.1n w=5.874u
M2a (n01 n01 vss vss) nch_lvt l=558.8n w=893.7n
M2b (VOUT n01 vss vss) nch_lvt l=558.8n w=893.7n
M3 (n02 vbp vdd vdd) pch_lvt l=130n w=1.329u
VBP (vbp vss) vsource dc=684.1m
ends amp
