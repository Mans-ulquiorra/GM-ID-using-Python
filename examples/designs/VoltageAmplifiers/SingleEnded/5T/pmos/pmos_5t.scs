parameters vcm=600m vout_dc=448m
subckt a010009 (VINN VINP VOUT vdd vss)
M1a (net02 VINP net19 vdd) pch_lvt l=280n w=6.19u
M1b (VOUT VINN net19 vdd) pch_lvt l=280n w=6.19u
M2a (net02 net02 vss vss) nch_lvt l=470.4n w=824.9n
M2b (VOUT net02 vss vss) nch_lvt l=470.4n w=824.9n
M3 (net19 vbp vdd vdd) pch_lvt l=130n w=589.8n
VBP (vbp vss) vsource dc=610.1m
ends a010009
